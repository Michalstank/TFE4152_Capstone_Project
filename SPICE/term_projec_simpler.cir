[aimspice]
[description]
715
TERM_PROJECT

!Focuses on creating a current mirror discussed in chapter 6.3.1

.include p18_cmos_models_tt.inc

! Uses design from fig 6.12 in CJM.
! Chosen n = 3.5
.param wl = 27
.param l = 2u
.param w = {l*wl}

VDD		Vdd	GND	3.3 dc
Vout		Out	GND	3.3 dc ! Changed during simulation

Ibias		Vdd 	Bias	50u
Iin		Vdd	In	40u ! Changed during simulation

!	Drain	Gate	Source	Base	Transistor Type and Size
m1 	Out	Bias	n1		GND 	NMOS L={l*12.25} W=w
m2 	n1	In	GND   	GND	NMOS L=l W=w
m3 	n2	In	GND		GND	NMOS L=l W=w
m4 	In	Bias	n2		GND	NMOS L={l*12.25} W=w
m5 	Bias	Bias 	GND		GND	NMOS L={l} W={w/20.25}

! Plot Output current alongside the Input current
.plot id(m1) id(m4)

.connect GND 0

[dc]
2
Vout
0
5
10m
Iin
40u
50u
5u
[ana]
1 0
[end]
